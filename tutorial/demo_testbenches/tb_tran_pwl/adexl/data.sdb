ADE simulation setup
Run mode: Single Run, Sweeps and Corners
Tests:
  tran: demo_testbenches/tb_tran_pwl/schematic, simulator spectre
Global variables:
  tsim = 5n
  tstep = 1p
