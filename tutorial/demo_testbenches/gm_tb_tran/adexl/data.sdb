ADE simulation setup
Run mode: Single Run, Sweeps and Corners
Tests:
  tb_tran: demo_testbenches/gm_tb_tran/schematic, simulator spectre
Global variables:
  tsim = 5n
  cload = 20f
  rload = 1000
  tper = 200p
  tr = 10p
  vamp = 100m
  vbias = 0.45
  vcm = 0.7
  vdd = 1.0
  tstep = 1p
