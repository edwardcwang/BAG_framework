procedure( compile_netlist_views(fname "t")
    let( (p line info_list lib cell view cv)
        unless( p = infile(fname)
            error("Cannot open file %s" fname)
        )
        while( gets(line p)
            info_list = parseString(line)
            lib = car(info_list)
            cell = cadr(info_list)
            view = caddr(info_list)
            cv = dbOpenCellViewByType(lib cell view "netlist" "ac")
            dbSave(cv)
            dbClose(cv)
        )
        close(p)
    )
)

compile_netlist_views("verilog_cell_list.txt")
